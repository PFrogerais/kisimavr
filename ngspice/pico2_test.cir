* Raspberry Pi Pico 2 (RP2350, RISC-V cores) model: GPIO, UART and ADC in SPICE
* Run from this folder:  ngspice pico2_test.cir
* Firmware: ../firmware/pico2/pico2_demo_riscv.bin (make -C ../firmware/pico2)
* rp2350js runs it inside mcu_cosim.so (QuickJS), booted by the RP2350 bootrom.

* Model generated for this firmware:
*   python3 ../tools/make_pico_lib.py --relative --mcu rp2350 \
*       --fw ../firmware/pico2/pico2_demo_riscv.bin \
*       --so ../build/mcu_cosim.so -o pico2.lib
.include pico2.lib

*     GP0 GP1 GP2 GP3 GP4 GP5 GP6 GP7 GP8 GP9 GP10 GP11 GP12 GP13 GP14 GP15 GP16
XP    tx  rx  n2  n3  n4  n5  n6  n7  n8  n9  n10  n11  n12  n13  btn  sq   led
*     GP17 GP18 GP19 GP20 GP21 GP22 GP26 GP27 GP28 VBUS VSYS V3V3_EN V3V3 ADC_VREF RUN
+     n17  n18  n19  n20  n21  n22  pot  n27  n28  vbus vsys en      v33  vref     run  PICO2

* GP26 (ADC0): divider 10k / 4.7k on 3.3 V -> 1.055 V, filtered
R1 v33 pot 10k
R2 pot 0 4.7k
C1 pot 0 10n
* GP14: push-button to GND, pressed from 3 ms to 6 ms (internal pull-up)
Sbtn btn 0 ctl 0 swbtn
Vctl ctl 0 PULSE(0 1 3m 1u 1u 3m 20m)
.model swbtn sw(vt=0.5 ron=10 roff=1e9)
* GP16: LED through 330 ohm
Rled led ledk 330
Dled ledk 0 dled
.model dled D(IS=1e-19 RS=10 N=2)
* UART: receiver load on TX, RX idle high
Rtx tx 0 100k
Rrx rx v33 10k

.control
tran 0.5u 10m
plot v(sq) v(led)+4 v(btn)+8 v(tx)+12
.endc
.end
